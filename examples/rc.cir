RC low-pass
V1 in 0 DC 0 AC 1 PULSE(0 1 0 1n 1n 10m 20m)
R1 in out 1k
C1 out 0 1u
.op
.ac dec 20 1 100k
.tran 10u 5m
.end
