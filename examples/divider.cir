10 V resistor divider: v(out) should be 5 V
V1 in 0 10
R1 in out 1k
R2 out 0 1k
.op
.end
